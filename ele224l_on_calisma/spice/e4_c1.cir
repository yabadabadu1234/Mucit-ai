* ELE224L
Vbb vbb 0 DC 5
Vcc vcc 0 DC 12
RB vbb b 150k
RC vcc c 2.2k
Q1 c b 0 BC238A
.model BC238A NPN(IS=7.7754e-14 BF=170 BR=1 RB=30 RC=1 CJE=8p CJC=3.5p TF=0.5n)
.control
set noaskquit
option numdgt=9
op
print v(c)
print v(b)
quit
.endc
.end
