* ELE224L
V1 a 0 SIN(0 5 1k)
D1 a b D1N4148
R1 b 0 1k
.model D1N4148 D(IS=2.52n RS=.568 N=1.752 CJO=4p M=.4 TT=20n)
.control
set noaskquit
set wr_vecnames
option numdgt=9
tran 2u 3m
wrdata /tmp/e1_tran.dat v(a) v(b)
quit
.endc
.end
