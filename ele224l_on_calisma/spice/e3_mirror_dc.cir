* ELE224L
VDD vdd 0 DC 15
Vi vi 0 DC 0
R1 vi d1 680
M1 d1 d1 0 0 BS170 W=100u L=100u
M2 d2 d1 0 0 BS170 W=100u L=100u
R2 vdd d2 1k
.model BS170 NMOS (VTO=2.1 RS=1.572 RD=1.436 KP=.1233 IS=5p)
.control
set noaskquit
set wr_vecnames
option numdgt=9
dc Vi 0 15 0.5
wrdata /tmp/e3_mirror_dc.dat i(vi) i(vdd)
quit
.endc
.end
