* ELE224L
VCC vcc 0 DC 12
Vi in 0 DC 0 AC 0
Cc1 in b 22n
R1 vcc b 22000
R2 b 0 39000
Q1 vcc b e BC238A
RE e 0 3300
Itest 0 e DC 0 AC 1
.model BC238A NPN(IS=7.7754e-14 BF=170 BR=1 RB=30 RC=1 CJE=8p CJC=3.5p TF=0.5n)
.control
set noaskquit
set wr_vecnames
option numdgt=9
ac lin 1 100k 100k
wrdata /tmp/e5_cc_ro.dat mag(v(e))
quit
.endc
.end
