* ELE224L
Vdd vdd 0 DC 6
Vin in 0 SIN(3 3 1k)
M1 out in 0 0 BS170 W=100u L=100u
M2 out in vdd vdd BS250 W=100u L=100u
.model BS170 NMOS (VTO=2.1 RS=1.572 RD=1.436 KP=.1233 IS=5p)
.model BS250 PMOS (VTO=-1.0 KP=150u LAMBDA=0.02 RD=1 RS=1 IS=20n)
.control
set noaskquit
set wr_vecnames
option numdgt=9
dc Vin 0 6 0.005
wrdata /tmp/e2_inv_dc.dat v(out) i(vdd)
quit
.endc
.end
