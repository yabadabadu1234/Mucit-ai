* ELE224L
V1 a 0 DC 5
D1 a b Deq
R1 b 0 1k
.model Deq D(IS=20f N=1 RS=0)
.control
set noaskquit
option numdgt=9
op
print v(a)
print v(b)
print i(v1)
quit
.endc
.end
