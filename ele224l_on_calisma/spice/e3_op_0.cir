* ELE224L
VDD vdd 0 DC 12
Vi in 0 DC 0
Cc1 in g 22n
R1 vdd g 47k
R2 g 0 33k
M1 d g s 0 BS170 W=100u L=100u
RD vdd d 15k
RS s 0 10k
Cc2 d o 2.2n
RL o 0 10k

.model BS170 NMOS (VTO=2.1 RS=1.572 RD=1.436 KP=.1233 IS=5p)
.control
set noaskquit
option numdgt=9
op
print v(g)
print v(s)
print v(d)
quit
.endc
.end
