* ELE224L
VDD vdd 0 DC 12
Vi in 0 DC 0 AC 0
Cc1 in g 22n
R1 vdd g 47k
R2 g 0 33k
M1 d g s 0 BS170 W=100u L=100u
RD vdd d 15k
RS s 0 10k
CS s 0 22n
Itest 0 d DC 0 AC 1

.model BS170 NMOS (VTO=2.1 RS=1.572 RD=1.436 KP=.1233 IS=5p)
.control
set noaskquit
set wr_vecnames
option numdgt=9
ac lin 1 10k 10k
wrdata /tmp/e3_rout.dat mag(v(d))
quit
.endc
.end
