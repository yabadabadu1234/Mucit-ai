* ELE224L
V1 a 0 DC 0
D1 a b D1N4148
R1 b 0 1k
.model D1N4148 D(IS=2.52n RS=.568 N=1.752 CJO=4p M=.4 TT=20n)
.control
set noaskquit
set wr_vecnames
option numdgt=9
dc v1 -5 5 0.01
wrdata /tmp/e1_dc_1n4148.dat v(a) v(b) i(v1)
quit
.endc
.end
