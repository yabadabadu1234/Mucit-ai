* ELE224L - e2_bs_dc
* ngspice ile uretildi/dogrulandi; LTspice'ta bu ortamda ACILMADI (File>Open ile acip calistirin).
V2 d 0 DC 5
V1 n1 0 DC 0
RG1 n1 g 33k
RG2 g 0 120k
M1 d g 0 0 BS170 W=100u L=100u
.model BS170 NMOS (VTO=2.1 RG=270 RS=1.572 RD=1.436 RB=.768
+ KP=.1233 Rds=1.2E8 IS=5p Tt=161.6n)
.dc V1 0 12.75 0.005
.end
