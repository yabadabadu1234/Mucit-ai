* ELE224L - e4_c2
* ngspice ile uretildi/dogrulandi; LTspice'ta bu ortamda ACILMADI (File>Open ile acip calistirin).
Vbb vbb 0 DC 5
Vcc vcc 0 DC 12
RB vbb b 22k
RC vcc c 1.2k
RE e 0 1k
Q1 c b e BC238A
.model BC238A NPN(IS=7.7754e-14 BF=170 BR=1 RB=30 RC=1 CJE=8p CJC=3.5p TF=0.5n)

.op
.end
