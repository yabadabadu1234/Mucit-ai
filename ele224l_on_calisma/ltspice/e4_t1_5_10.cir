* ELE224L - e4_t1_5_10
* ngspice ile uretildi/dogrulandi; LTspice'ta bu ortamda ACILMADI (File>Open ile acip calistirin).
Vbb vbb 0 DC 5
Vcc vcc 0 DC 10
RB vbb b 150000
RC vcc c 2200
RE e 0 1000
Q1 c b e BC238A
.model BC238A NPN(IS=7.7754e-14 BF=170 BR=1 RB=30 RC=1 CJE=8p CJC=3.5p TF=0.5n)

.op
.end
