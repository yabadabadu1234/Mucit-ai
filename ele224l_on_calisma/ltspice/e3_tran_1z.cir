* ELE224L - e3_tran_1
* ngspice ile uretildi/dogrulandi; LTspice'ta bu ortamda ACILMADI (File>Open ile acip calistirin).
VDD vdd 0 DC 12
Vi in 0 DC 0 AC 1 SIN(0 0.1 10k)
Cc1 in g 22n
R1 vdd g 47k
R2 g 0 33k
M1 d g s 0 BS170 W=100u L=100u
RD vdd d 15k
RS s 0 10k
CS s 0 22n
Cc2 d o 2.2n
RL o 0 10k

.model BS170 NMOS (VTO=2.1 RG=270 RS=1.572 RD=1.436 RB=.768
+ KP=.1233 Rds=1.2E8 IS=5p Tt=161.6n)
.tran 0 7.5m 7m 1u
.end
